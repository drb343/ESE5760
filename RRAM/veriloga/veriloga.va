// VerilogA for ESE5760, RRAM, veriloga
`include "disciplines.vams"
`include "constants.vams"

module RRAM_v_2_0_Beta(t,b) ;

        electrical t , b ;
        inout t , b ;

        parameter real a = 0.25e-9 ;
        parameter real f = 1e13 ;
        parameter real Ea = 0.7 ;
        parameter real Eh = 1.12 ;
        parameter real Ei = 0.82 ;
        parameter real r = 1.5 ;
        parameter real alphah = 0.75e-9 ;
        parameter real alpha = 0.75e-9 ;
        parameter real Z = 1 ;
        parameter real XT = 0.4e-9 ;
        parameter real VT = 0.4 ;
        parameter real L0 = 3e-9 ;
        parameter real x0 = 3e-9 ;
        parameter real w0 = 0.5e-9 ;
        parameter real WCF = 5e-9 ;
        parameter real weff = 0.5e-9 ;
        parameter real I0 = 1e13 ;
        parameter real rou = 1.9635e-5 ;
        parameter real pi = 3.1415926 ;
        parameter real Rth = 5e5 ;
        parameter real Kb = 8.61733e-5 ;
        parameter real T0 = 300 ;
        parameter real switch = 0 ;
        parameter real deltaGap = 4e-5 ;
        parameter real deltaCF = 1e-4 ;
        parameter real crit_x = 0.5e-9 ;
        parameter real user_seed = 0 ;

        real Temp ;
        real dxr1 ;
        real dxr2 ;
        real dxs ;
        real dx ;
        real dw ;
        real x ;
        real w ;
        real RCF ;
        real Vg ;
        real I1 ;
        integer rand_seed_set ;
        integer rand_seed_reset ;
        real cf_random_ddt ;
        real gap_random_ddt ;

        analog
        begin
                Temp = T0 + abs(I(t,b) * V(t,b)) * Rth ;
                I1 = I0*pi*(WCF*WCF/4-w*w/4)*exp(-L0/XT)*sinh(V(t,b)/VT) ;
                RCF = rou*(L0-x)/(pi*w*w/4) ;
                Vg = V(t,b) - (I(t,b)-I1)*RCF ;

                dx = 0 ;
                dw = 0 ;

                if ( V(t,b) > 0 )
                begin
                        if ( x > 0 )
                        begin
                                dxs = -a*f*exp(-(Ea-Vg*alpha*Z/x)/(Kb*Temp)) ;
                                if ( abs(dxs) <= 1e2 )
                                begin
                                        dx = dxs ;
                                end
                                else
                                begin
                                        dx = -1e2 ;
                                end
                        end
                        else if ( x <= 0 )
                        begin
                                dx = 0 ;
                        end

                        if ( w < WCF )
                        begin
                                dw = (x>0)*0 + (x<=0)*(weff+pow(weff,2)/(2*w))*f*exp(-(Ea-V(t,b)*alpha*Z/L0)/(Kb*Temp)) ;
                                if ( dw > 1e2 )
                                begin
                                        dw = 1e2 ;
                                end
                        end
                        else if ( w >= WCF)
                                dw = 0 ;
                end
                else if ( V(t,b) < 0 )
                begin
                        dw = 0 ;
                        if ( x <= 0 )
                        begin
                                dxr1 = a*f*exp(-(Ei+r*Z*Vg)/(Kb*Temp)) ;
                                dx = dxr1 ;
                        end
                        else if ( x > 0 )
                        begin
                                if ( x < L0 )
                                begin
                                        dxr1 = a*f*exp(-(Ei+r*Z*Vg)/(Kb*Temp)) ;
                                        dxr2 = a*f*exp(-Eh/(Kb*Temp))*sinh(alphah*Z*-1*Vg/(x*Kb*Temp)) ;
                                        dx = (dxr1<dxr2)*dxr1 + (dxr2<=dxr1)*dxr2 ;
                                end
                                else if ( x >= L0 )
                                begin
                                        dx = 0 ;
                                end
                        end
                end
                else
                begin
                        dx = 0 ;
                        dw = 0 ;
                end

                if ( V(t,b) == 0 )
                begin
                        I(t,b) <+ 0 ;
                end
                else if ( V(t,b) > 0 )
                begin
                        if ( x > 0 )
                        begin
                                I(t,b) <+ I1 + I0*pi*(w*w/4)*exp(-x/XT)*sinh(Vg/VT) ;
                        end
                        else if ( x <= 0 )
                        begin
                                I(t,b) <+ I1 + V(t,b)/(rou*L0/(pi*w*w/4)) ;
                        end
                end
                else if ( V(t,b) < 0 )
                begin
                        I(t,b) <+ I1 + I0*pi*(w*w/4)*exp(-x/XT)*sinh(Vg/VT) ;
                end

                cf_random_ddt = 0 ;
                gap_random_ddt = 0 ;

                if ( switch == 1 )
                begin
                        if ( V(t,b) > 0 )
                        begin
                                if ( dw != 0 )
                                begin
                                        rand_seed_set = $random ;
                                        cf_random_ddt = $dist_normal(rand_seed_set,0,1) * deltaCF ;
                                end
                        end
                        else if ( V(t,b) < 0 )
                        begin
                                if ( x >= crit_x )
                                begin
                                        rand_seed_reset = $random ;
                                        gap_random_ddt = $dist_normal(rand_seed_reset,0,1) * deltaGap ;
                                end
                        end
                end

                x = idt(dx+gap_random_ddt,x0) ;
                w = idt(dw+cf_random_ddt,w0) ;

                if ( x < 0 )
                begin
                        x = 0 ;
                end
                if ( x > L0 )
                begin
                        x = L0 ;
                end
                if ( w > WCF )
                begin
                        w = WCF ;
                end
        end
endmodule
